# Ansys Electronics Desktop project, version 2017.1
materials:
  air: permittivity=1.0006 permeability=1.0000004
  copper: permeability=0.999991 conductivity=58000000
  FR4_epoxy: permittivity=4.4 dielectric_loss_tangent=0.02
  pec: conductivity=1e+030
  vacuum: permittivity=1

design 1 - Straight Line GH50 (HFSS 3D Layout)
variables:
  Xsize = 6*(5*linewidth+4*trace_space)
  Ysize = 500mil
  Gapwidth = 500mil
  gap_height = 50mil
  linewidth = 10mil
  Trace_Space = 20mil
ports:
  Port10:T10: Properties{Reference=GND:GND:rect_0 Impedance=50ohm Magnitude=1V Phase=0deg PostProcess Renormalize="50ohm + 0i ohm" Deembed=0mm Type="Coupled Strips Gap Source" HFSS_Type=Wave Orientation=Vertical Layer_Alignment=Upper Horizontal_Extent_Factor=3 Vertical_Extent_Factor=5 PEC_Launch_Width=1.4mil} Type=EdgePortCoupledStrip OrderId=6
  Port10:T2: Properties{Reference=GND:GND:rect_0 Impedance=50ohm Magnitude=1V Phase=0deg PostProcess Renormalize="50ohm + 0i ohm" Deembed=0mm Type="Coupled Strips Gap Source" HFSS_Type=Wave Orientation=Vertical Layer_Alignment=Upper Horizontal_Extent_Factor=3 Vertical_Extent_Factor=5 PEC_Launch_Width=1.4mil} Type=EdgePortCoupledStrip OrderId=10
  Port10:T4: Properties{Reference=GND:GND:rect_0 Impedance=50ohm Magnitude=1V Phase=0deg PostProcess Renormalize="50ohm + 0i ohm" Deembed=0mm Type="Coupled Strips Gap Source" HFSS_Type=Wave Orientation=Vertical Layer_Alignment=Upper Horizontal_Extent_Factor=3 Vertical_Extent_Factor=5 PEC_Launch_Width=1.4mil} Type=EdgePortCoupledStrip OrderId=9
  Port10:T6: Properties{Reference=GND:GND:rect_0 Impedance=50ohm Magnitude=1V Phase=0deg PostProcess Renormalize="50ohm + 0i ohm" Deembed=0mm Type="Coupled Strips Gap Source" HFSS_Type=Wave Orientation=Vertical Layer_Alignment=Upper Horizontal_Extent_Factor=3 Vertical_Extent_Factor=5 PEC_Launch_Width=1.4mil} Type=EdgePortCoupledStrip OrderId=8
  Port10:T8: Properties{Reference=GND:GND:rect_0 Impedance=50ohm Magnitude=1V Phase=0deg PostProcess Renormalize="50ohm + 0i ohm" Deembed=0mm Type="Coupled Strips Gap Source" HFSS_Type=Wave Orientation=Vertical Layer_Alignment=Upper Horizontal_Extent_Factor=3 Vertical_Extent_Factor=5 PEC_Launch_Width=1.4mil} Type=EdgePortCoupledStrip OrderId=7
  Port1:T1: Properties{Reference=GND:GND:rect_0 Impedance=50ohm Magnitude=1V Phase=0deg PostProcess Renormalize="50ohm + 0i ohm" Deembed=0mm Type="Coupled Strips Gap Source" HFSS_Type=Wave Orientation=Vertical Layer_Alignment=Upper Horizontal_Extent_Factor=3 Vertical_Extent_Factor=5 PEC_Launch_Width=1.4mil} Type=EdgePortCoupledStrip OrderId=1
  Port1:T3: Properties{Reference=GND:GND:rect_0 Impedance=50ohm Magnitude=1V Phase=0deg PostProcess Renormalize="50ohm + 0i ohm" Deembed=0mm Type="Coupled Strips Gap Source" HFSS_Type=Wave Orientation=Vertical Layer_Alignment=Upper Horizontal_Extent_Factor=3 Vertical_Extent_Factor=5 PEC_Launch_Width=1.4mil} Type=EdgePortCoupledStrip OrderId=2
  Port1:T5: Properties{Reference=GND:GND:rect_0 Impedance=50ohm Magnitude=1V Phase=0deg PostProcess Renormalize="50ohm + 0i ohm" Deembed=0mm Type="Coupled Strips Gap Source" HFSS_Type=Wave Orientation=Vertical Layer_Alignment=Upper Horizontal_Extent_Factor=3 Vertical_Extent_Factor=5 PEC_Launch_Width=1.4mil} Type=EdgePortCoupledStrip OrderId=3
  Port1:T7: Properties{Reference=GND:GND:rect_0 Impedance=50ohm Magnitude=1V Phase=0deg PostProcess Renormalize="50ohm + 0i ohm" Deembed=0mm Type="Coupled Strips Gap Source" HFSS_Type=Wave Orientation=Vertical Layer_Alignment=Upper Horizontal_Extent_Factor=3 Vertical_Extent_Factor=5 PEC_Launch_Width=1.4mil} Type=EdgePortCoupledStrip OrderId=4
  Port1:T9: Properties{Reference=GND:GND:rect_0 Impedance=50ohm Magnitude=1V Phase=0deg PostProcess Renormalize="50ohm + 0i ohm" Deembed=0mm Type="Coupled Strips Gap Source" HFSS_Type=Wave Orientation=Vertical Layer_Alignment=Upper Horizontal_Extent_Factor=3 Vertical_Extent_Factor=5 PEC_Launch_Width=1.4mil} Type=EdgePortCoupledStrip OrderId=5
setups:
  HFSS Setup 1: SolveSetupType=HFSS PercentRefinementPerPass=30 MinNumberOfPasses=1 MinNumberOfConvergedPasses=1 Frequency=10GHz MeshSizeFactor=1.5 ViaNumSides=6 ViaMaterial=copper Style25DVia=Mesh
    sweep Sweep 1: LIN 0GHz 50GHz 0.05GHz; SweepSetupType=Ensemble FastSweep SAbsError=0.005 ZoPercentError=1 PassivityTolerance=0.0001 MaxSolutions=250 InterpUseSMatrix InterpUsePortImpedance InterpUseFullBasis MagMinThreshold=0.01
reports:
  S Parameter Plot 1: dB(S(Port1:T1,Port1:T1)), dB(S(Port1:T3,Port1:T3)), dB(S(Port1:T5,Port1:T5)), dB(S(Port1:T7,Port1:T7)), dB(S(Port1:T9,Port1:T9)), dB(S(Port10:T2,Port10:T2)), dB(S(Port10:T4,Port10:T4)), dB(S(Port10:T6,Port10:T6)), dB(S(Port10:T8,Port10:T8)), dB(S(Port10:T10,Port10:T10)) vs F on HFSS Setup 1 : Sweep 1
  S Parameter Plot 2: dB(S(Port1:T1,Port10:T2)), dB(S(Port1:T3,Port10:T4)), dB(S(Port1:T5,Port10:T6)), dB(S(Port1:T7,Port10:T8)), dB(S(Port1:T9,Port10:T10)) vs F on HFSS Setup 1 : Sweep 1
